* sparx_wpd_le - lumped-element equivalent (Ngspice / SPICE3)
* generated by snp2le
* EQUIVALENT CIRCUIT FOR VECTOR FITTED S-MATRIX
* Created using scikit-rf vectorFitting.py
*
*
.SUBCKT sparx_wpd_le p1 p2 p3
V1 p1 s1 0
R1 s1 0 50 noisy=0
Gd1_1 0 s1 p1 0 -0.004161717648
Fd1_1 0 s1 V1 -0.2080858824
Gr1_re_1_1 0 s1 x1_re_a1 0 -370728.4093
Gr1_im_1_1 0 s1 x1_im_a1 0 543158.7544
Gr2_1_1 0 s1 x2_a1 0 -0.2586478393
Gr3_re_1_1 0 s1 x3_re_a1 0 21348.0309
Gr3_im_1_1 0 s1 x3_im_a1 0 16824.14671
Gr4_re_1_1 0 s1 x4_re_a1 0 345321.5079
Gr4_im_1_1 0 s1 x4_im_a1 0 195211.1698
Gd1_2 0 s1 p2 0 0.0003317963021
Fd1_2 0 s1 V2 0.0165898151
Gr1_re_1_2 0 s1 x1_re_a2 0 -119110.6641
Gr1_im_1_2 0 s1 x1_im_a2 0 524369.5022
Gr2_1_2 0 s1 x2_a2 0 0.0303281868
Gr3_re_1_2 0 s1 x3_re_a2 0 4099.166294
Gr3_im_1_2 0 s1 x3_im_a2 0 -8922.868323
Gr4_re_1_2 0 s1 x4_re_a2 0 84971.33082
Gr4_im_1_2 0 s1 x4_im_a2 0 -326125.8869
Gd1_3 0 s1 p3 0 0.0004053296778
Fd1_3 0 s1 V3 0.02026648389
Gr1_re_1_3 0 s1 x1_re_a3 0 -120447.9831
Gr1_im_1_3 0 s1 x1_im_a3 0 520047.4081
Gr2_1_3 0 s1 x2_a3 0 0.02986572024
Gr3_re_1_3 0 s1 x3_re_a3 0 3207.378799
Gr3_im_1_3 0 s1 x3_im_a3 0 -8556.051135
Gr4_re_1_3 0 s1 x4_re_a3 0 83156.04782
Gr4_im_1_3 0 s1 x4_im_a3 0 -326404.4133
Cx1_re_a1 x1_re_a1 0 7.640485663e-13
Gx1_re_a1 0 x1_re_a1 p1 0 3.675912343e-08
Fx1_re_a1 0 x1_re_a1 V1 1.837956172e-06
Rp1_re_re_a1 0 x1_re_a1 1 noisy=0
Gp1_re_im_a1 0 x1_re_a1 x1_im_a1 0 1.85380279
Cx1_im_a1 x1_im_a1 0 7.640485663e-13
Gp1_im_re_a1 0 x1_im_a1 x1_re_a1 0 -1.85380279
Rp1_im_im_a1 0 x1_im_a1 1 noisy=0
Cx2_a1 x2_a1 0 1.665780508e-12
Gx2_a1 0 x2_a1 p1 0 0.005172956786
Fx2_a1 0 x2_a1 V1 0.2586478393
Rp2_a1 0 x2_a1 1 noisy=0
Cx3_re_a1 x3_re_a1 0 1.083174858e-11
Gx3_re_a1 0 x3_re_a1 p1 0 1.921901346e-09
Fx3_re_a1 0 x3_re_a1 V1 9.609506729e-08
Rp3_re_re_a1 0 x3_re_a1 1 noisy=0
Gp3_re_im_a1 0 x3_re_a1 x3_im_a1 0 16.30509969
Cx3_im_a1 x3_im_a1 0 1.083174858e-11
Gp3_im_re_a1 0 x3_im_a1 x3_re_a1 0 -16.30509969
Rp3_im_im_a1 0 x3_im_a1 1 noisy=0
Cx4_re_a1 x4_re_a1 0 6.524711207e-13
Gx4_re_a1 0 x4_re_a1 p1 0 7.423635002e-08
Fx4_re_a1 0 x4_re_a1 V1 3.711817501e-06
Rp4_re_re_a1 0 x4_re_a1 1 noisy=0
Gp4_re_im_a1 0 x4_re_a1 x4_im_a1 0 0.5827776629
Cx4_im_a1 x4_im_a1 0 6.524711207e-13
Gp4_im_re_a1 0 x4_im_a1 x4_re_a1 0 -0.5827776629
Rp4_im_im_a1 0 x4_im_a1 1 noisy=0
V2 p2 s2 0
R2 s2 0 50 noisy=0
Gd2_1 0 s2 p1 0 0.0003317963021
Fd2_1 0 s2 V1 0.0165898151
Gr1_re_2_1 0 s2 x1_re_a1 0 -243692.848
Gr1_im_2_1 0 s2 x1_im_a1 0 1072826.672
Gr2_2_1 0 s2 x2_a1 0 0.09243898162
Gr3_re_2_1 0 s2 x3_re_a1 0 9005.652639
Gr3_im_2_1 0 s2 x3_im_a1 0 -19603.07216
Gr4_re_2_1 0 s2 x4_re_a1 0 165721.6323
Gr4_im_2_1 0 s2 x4_im_a1 0 -636051.1693
Gd2_2 0 s2 p2 0 -0.006700348778
Fd2_2 0 s2 V2 -0.3350174389
Gr1_re_2_2 0 s2 x1_re_a2 0 -565064.6548
Gr1_im_2_2 0 s2 x1_im_a2 0 1045733.484
Gr2_2_2 0 s2 x2_a2 0 -0.7633155011
Gr3_re_2_2 0 s2 x3_re_a2 0 14637.40379
Gr3_im_2_2 0 s2 x3_im_a2 0 -35170.41039
Gr4_re_2_2 0 s2 x4_re_a2 0 760240.3638
Gr4_im_2_2 0 s2 x4_im_a2 0 352044.1976
Gd2_3 0 s2 p3 0 0.01819560296
Fd2_3 0 s2 V3 0.9097801482
Gr1_re_2_3 0 s2 x1_re_a3 0 930308.0319
Gr1_im_2_3 0 s2 x1_im_a3 0 -1789546.281
Gr2_2_3 0 s2 x2_a3 0 0.7883472568
Gr3_re_2_3 0 s2 x3_re_a3 0 -57608.28021
Gr3_im_2_3 0 s2 x3_im_a3 0 23591.55496
Gr4_re_2_3 0 s2 x4_re_a3 0 -1253010.511
Gr4_im_2_3 0 s2 x4_im_a3 0 -667337.1206
Cx1_re_a2 x1_re_a2 0 7.640485663e-13
Gx1_re_a2 0 x1_re_a2 p2 0 7.520683012e-08
Fx1_re_a2 0 x1_re_a2 V2 3.760341506e-06
Rp1_re_re_a2 0 x1_re_a2 1 noisy=0
Gp1_re_im_a2 0 x1_re_a2 x1_im_a2 0 1.85380279
Cx1_im_a2 x1_im_a2 0 7.640485663e-13
Gp1_im_re_a2 0 x1_im_a2 x1_re_a2 0 -1.85380279
Rp1_im_im_a2 0 x1_im_a2 1 noisy=0
Cx2_a2 x2_a2 0 1.665780508e-12
Gx2_a2 0 x2_a2 p2 0 0.01576694514
Fx2_a2 0 x2_a2 V2 0.7883472568
Rp2_a2 0 x2_a2 1 noisy=0
Cx3_re_a2 x3_re_a2 0 1.083174858e-11
Gx3_re_a2 0 x3_re_a2 p2 0 4.222316121e-09
Fx3_re_a2 0 x3_re_a2 V2 2.11115806e-07
Rp3_re_re_a2 0 x3_re_a2 1 noisy=0
Gp3_re_im_a2 0 x3_re_a2 x3_im_a2 0 16.30509969
Cx3_im_a2 x3_im_a2 0 1.083174858e-11
Gp3_im_re_a2 0 x3_im_a2 x3_re_a2 0 -16.30509969
Rp3_im_im_a2 0 x3_im_a2 1 noisy=0
Cx4_re_a2 x4_re_a2 0 6.524711207e-13
Gx4_re_a2 0 x4_re_a2 p2 0 1.447849408e-07
Fx4_re_a2 0 x4_re_a2 V2 7.239247041e-06
Rp4_re_re_a2 0 x4_re_a2 1 noisy=0
Gp4_re_im_a2 0 x4_re_a2 x4_im_a2 0 0.5827776629
Cx4_im_a2 x4_im_a2 0 6.524711207e-13
Gp4_im_re_a2 0 x4_im_a2 x4_re_a2 0 -0.5827776629
Rp4_im_im_a2 0 x4_im_a2 1 noisy=0
V3 p3 s3 0
R3 s3 0 50 noisy=0
Gd3_1 0 s3 p1 0 0.0004053296778
Fd3_1 0 s3 V1 0.02026648389
Gr1_re_3_1 0 s3 x1_re_a1 0 -246428.9178
Gr1_im_3_1 0 s3 x1_im_a1 0 1063983.942
Gr2_3_1 0 s3 x2_a1 0 0.09102940386
Gr3_re_3_1 0 s3 x3_re_a1 0 7024.716998
Gr3_im_3_1 0 s3 x3_im_a1 0 -18739.23899
Gr4_re_3_1 0 s3 x4_re_a1 0 162181.2422
Gr4_im_3_1 0 s3 x4_im_a1 0 -636594.3861
Gd3_2 0 s3 p2 0 0.01819560296
Fd3_2 0 s3 V2 0.9097801482
Gr1_re_3_2 0 s3 x1_re_a2 0 930308.0319
Gr1_im_3_2 0 s3 x1_im_a2 0 -1789546.281
Gr2_3_2 0 s3 x2_a2 0 0.7883472568
Gr3_re_3_2 0 s3 x3_re_a2 0 -57430.66357
Gr3_im_3_2 0 s3 x3_im_a2 0 23518.81797
Gr4_re_3_2 0 s3 x4_re_a2 0 -1253010.511
Gr4_im_3_2 0 s3 x4_im_a2 0 -667337.1206
Gd3_3 0 s3 p3 0 -0.006637326168
Fd3_3 0 s3 V3 -0.3318663084
Gr1_re_3_3 0 s3 x1_re_a3 0 -565867.0092
Gr1_im_3_3 0 s3 x1_im_a3 0 1044132.948
Gr2_3_3 0 s3 x2_a3 0 -0.7628796936
Gr3_re_3_3 0 s3 x3_re_a3 0 14043.10373
Gr3_im_3_3 0 s3 x3_im_a3 0 -34846.10235
Gr4_re_3_3 0 s3 x4_re_a3 0 759375.5414
Gr4_im_3_3 0 s3 x4_im_a3 0 352237.8676
Cx1_re_a3 x1_re_a3 0 7.640485663e-13
Gx1_re_a3 0 x1_re_a3 p3 0 7.520683012e-08
Fx1_re_a3 0 x1_re_a3 V3 3.760341506e-06
Rp1_re_re_a3 0 x1_re_a3 1 noisy=0
Gp1_re_im_a3 0 x1_re_a3 x1_im_a3 0 1.85380279
Cx1_im_a3 x1_im_a3 0 7.640485663e-13
Gp1_im_re_a3 0 x1_im_a3 x1_re_a3 0 -1.85380279
Rp1_im_im_a3 0 x1_im_a3 1 noisy=0
Cx2_a3 x2_a3 0 1.665780508e-12
Gx2_a3 0 x2_a3 p3 0 0.01576694514
Fx2_a3 0 x2_a3 V3 0.7883472568
Rp2_a3 0 x2_a3 1 noisy=0
Cx3_re_a3 x3_re_a3 0 1.083174858e-11
Gx3_re_a3 0 x3_re_a3 p3 0 4.209297964e-09
Fx3_re_a3 0 x3_re_a3 V3 2.104648982e-07
Rp3_re_re_a3 0 x3_re_a3 1 noisy=0
Gp3_re_im_a3 0 x3_re_a3 x3_im_a3 0 16.30509969
Cx3_im_a3 x3_im_a3 0 1.083174858e-11
Gp3_im_re_a3 0 x3_im_a3 x3_re_a3 0 -16.30509969
Rp3_im_im_a3 0 x3_im_a3 1 noisy=0
Cx4_re_a3 x4_re_a3 0 6.524711207e-13
Gx4_re_a3 0 x4_re_a3 p3 0 1.447849408e-07
Fx4_re_a3 0 x4_re_a3 V3 7.239247041e-06
Rp4_re_re_a3 0 x4_re_a3 1 noisy=0
Gp4_re_im_a3 0 x4_re_a3 x4_im_a3 0 0.5827776629
Cx4_im_a3 x4_im_a3 0 6.524711207e-13
Gp4_im_re_a3 0 x4_im_a3 x4_re_a3 0 -0.5827776629
Rp4_im_im_a3 0 x4_im_a3 1 noisy=0
.ENDS sparx_wpd_le
